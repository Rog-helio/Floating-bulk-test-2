* SPICE3 file created from tt_um_rog_helio_.ext - technology: sky130A

X0 ua[0] ua[4] ua[1] w_22248_2380# sky130_fd_pr__nfet_01v8 ad=0.1218 pd=1.42 as=0.1218 ps=1.42 w=0.42 l=0.15
X1 ua[2] ua[3] w_22248_2380# ua[2] sky130_fd_pr__nfet_01v8 ad=0.1218 pd=1.42 as=0.1218 ps=1.42 w=0.42 l=0.15
C0 ua[3] ua[0] 0.01547f
C1 clk rst_n 0.03102f
C2 uo_out[1] uo_out[2] 0.03102f
C3 uio_in[5] uio_in[4] 0.03102f
C4 w_22248_2380# ua[0] 3.17898f
C5 uio_oe[3] uio_oe[2] 0.03102f
C6 uo_out[7] uio_out[0] 0.03102f
C7 uio_in[4] uio_in[3] 0.03102f
C8 uio_oe[4] uio_oe[3] 0.03102f
C9 uio_in[2] uio_in[3] 0.03102f
C10 ui_in[1] ui_in[0] 0.03102f
C11 ua[4] ua[1] 0.04778f
C12 ui_in[6] ui_in[5] 0.03102f
C13 uio_out[1] uio_out[0] 0.03102f
C14 uio_in[1] uio_in[0] 0.03102f
C15 uio_out[3] uio_out[2] 0.03102f
C16 uio_out[6] uio_out[7] 0.03102f
C17 uio_out[7] uio_oe[0] 0.03102f
C18 ui_in[4] ui_in[3] 0.03102f
C19 clk ena 0.03102f
C20 uo_out[6] uo_out[5] 0.03102f
C21 uio_out[1] uio_out[2] 0.03102f
C22 uio_oe[6] uio_oe[7] 0.03102f
C23 ui_in[7] uio_in[0] 0.03102f
C24 w_22248_2380# ua[1] 0.47259f
C25 uo_out[3] uo_out[4] 0.03102f
C26 uio_in[7] uio_in[6] 0.03102f
C27 uio_out[3] uio_out[4] 0.03102f
C28 uio_in[5] uio_in[6] 0.03102f
C29 ua[0] ua[1] 0.4033f
C30 uio_oe[1] uio_oe[2] 0.03102f
C31 ui_in[1] ui_in[2] 0.03102f
C32 ui_in[0] rst_n 0.03102f
C33 uo_out[0] uio_in[7] 0.03102f
C34 uio_out[5] uio_out[4] 0.03102f
C35 VGND VDPWR 12.9181f
C36 ua[4] w_22248_2380# 0.275f
C37 uo_out[3] uo_out[2] 0.03102f
C38 ui_in[4] ui_in[5] 0.03102f
C39 uo_out[7] uo_out[6] 0.03102f
C40 ua[4] ua[0] 0.54527f
C41 uio_oe[6] uio_oe[5] 0.03102f
C42 ui_in[3] ui_in[2] 0.03102f
C43 uo_out[0] uo_out[1] 0.03102f
C44 uio_oe[4] uio_oe[5] 0.03102f
C45 ua[3] w_22248_2380# 0.07418f
C46 uo_out[4] uo_out[5] 0.03102f
C47 uio_in[2] uio_in[1] 0.03102f
C48 uio_out[6] uio_out[5] 0.03102f
C49 uio_oe[0] uio_oe[1] 0.03102f
C50 ui_in[6] ui_in[7] 0.03102f
C51 ua[5] ua[2] 0.14696f
C52 ua[6] ua[2] 0.14696f
C53 ua[7] ua[2] 0.14696f
C54 VGND ua[2] 12.5347f
C55 VDPWR ua[2] 12.5347f
C56 ena ua[2] 0.07038f
C57 clk ua[2] 0.04288f
C58 rst_n ua[2] 0.04288f
C59 ui_in[0] ua[2] 0.04288f
C60 ui_in[1] ua[2] 0.04288f
C61 ui_in[2] ua[2] 0.04288f
C62 ui_in[3] ua[2] 0.04288f
C63 ui_in[4] ua[2] 0.04288f
C64 ui_in[5] ua[2] 0.04288f
C65 ui_in[6] ua[2] 0.04288f
C66 ui_in[7] ua[2] 0.04288f
C67 uio_in[0] ua[2] 0.04288f
C68 uio_in[1] ua[2] 0.04288f
C69 uio_in[2] ua[2] 0.04288f
C70 uio_in[3] ua[2] 0.04288f
C71 uio_in[4] ua[2] 0.04288f
C72 uio_in[5] ua[2] 0.04288f
C73 uio_in[6] ua[2] 0.04288f
C74 uio_in[7] ua[2] 0.04288f
C75 uo_out[0] ua[2] 0.04288f
C76 uo_out[1] ua[2] 0.04288f
C77 uo_out[2] ua[2] 0.04288f
C78 uo_out[3] ua[2] 0.04288f
C79 uo_out[4] ua[2] 0.04288f
C80 uo_out[5] ua[2] 0.04288f
C81 uo_out[6] ua[2] 0.04288f
C82 uo_out[7] ua[2] 0.04288f
C83 uio_out[0] ua[2] 0.04288f
C84 uio_out[1] ua[2] 0.04288f
C85 uio_out[2] ua[2] 0.04288f
C86 uio_out[3] ua[2] 0.04288f
C87 uio_out[4] ua[2] 0.04288f
C88 uio_out[5] ua[2] 0.04288f
C89 uio_out[6] ua[2] 0.04288f
C90 uio_out[7] ua[2] 0.04288f
C91 uio_oe[0] ua[2] 0.04288f
C92 uio_oe[1] ua[2] 0.04288f
C93 uio_oe[2] ua[2] 0.04288f
C94 uio_oe[3] ua[2] 0.04288f
C95 uio_oe[4] ua[2] 0.04288f
C96 uio_oe[5] ua[2] 0.04288f
C97 uio_oe[6] ua[2] 0.04288f
C98 uio_oe[7] ua[2] 0.07038f
C99 ua[3] ua[2] 2.70678f
C100 ua[1] ua[2] 2.23135f
C101 ua[4] ua[2] 5.79087f
C102 w_22248_2380# ua[2] 0.53527f **FLOATING
C103 ua[0] ua[2] 13.90031f
