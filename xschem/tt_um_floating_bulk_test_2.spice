* SPICE3 file created from tt_um_floating_bulk_test_2.ext - technology: sky130A

X0 ua[0] ua[4] ua[1] w_22268_1880# sky130_fd_pr__nfet_01v8 ad=0.1218 pd=1.42 as=0.1218 ps=1.42 w=0.42 l=0.15
X1 ua[2] ua[3] w_22268_1880# ua[2] sky130_fd_pr__nfet_01v8 ad=0.1218 pd=1.42 as=0.1218 ps=1.42 w=0.42 l=0.15
C0 rst_n ui_in[0] 0.03102f
C1 ui_in[6] ui_in[5] 0.03102f
C2 ua[1] w_22268_1880# 0.4728f
C3 ui_in[6] ui_in[7] 0.03102f
C4 uio_in[5] uio_in[4] 0.03102f
C5 uio_in[1] uio_in[0] 0.03102f
C6 uio_in[6] uio_in[7] 0.03102f
C7 ui_in[5] ui_in[4] 0.03102f
C8 ui_in[3] ui_in[2] 0.03102f
C9 ua[1] ua[0] 0.40621f
C10 w_22268_1880# ua[4] 0.275f
C11 ui_in[2] ui_in[1] 0.03102f
C12 uio_in[3] uio_in[2] 0.03102f
C13 clk rst_n 0.03102f
C14 VGND VDPWR 12.9181f
C15 ua[0] ua[4] 0.54542f
C16 ua[3] w_22268_1880# 0.07418f
C17 uio_in[5] uio_in[6] 0.03102f
C18 ua[0] w_22268_1880# 3.17898f
C19 uio_in[0] ui_in[7] 0.03102f
C20 ua[0] ua[3] 0.01547f
C21 uio_in[3] uio_in[4] 0.03102f
C22 uio_in[7] VGND 0.03102f
C23 ui_in[1] ui_in[0] 0.03102f
C24 ui_in[3] ui_in[4] 0.03102f
C25 uio_in[1] uio_in[2] 0.03102f
C26 clk ena 0.03102f
C27 ua[1] ua[4] 0.04778f
C28 ua[5] ua[2] 0.14696f
C29 ua[6] ua[2] 0.14696f
C30 ua[7] ua[2] 0.14696f
C31 VDPWR ua[2] 12.5347f
C32 ena ua[2] 0.07038f
C33 clk ua[2] 0.04288f
C34 rst_n ua[2] 0.04288f
C35 ui_in[0] ua[2] 0.04288f
C36 ui_in[1] ua[2] 0.04288f
C37 ui_in[2] ua[2] 0.04288f
C38 ui_in[3] ua[2] 0.04288f
C39 ui_in[4] ua[2] 0.04288f
C40 ui_in[5] ua[2] 0.04288f
C41 ui_in[6] ua[2] 0.04288f
C42 ui_in[7] ua[2] 0.04288f
C43 uio_in[0] ua[2] 0.04288f
C44 uio_in[1] ua[2] 0.04288f
C45 uio_in[2] ua[2] 0.04288f
C46 uio_in[3] ua[2] 0.04288f
C47 uio_in[4] ua[2] 0.04288f
C48 uio_in[5] ua[2] 0.04288f
C49 uio_in[6] ua[2] 0.04288f
C50 uio_in[7] ua[2] 0.04288f
C51 VGND ua[2] 20.2701f
C52 ua[3] ua[2] 2.66691f
C53 ua[1] ua[2] 1.53041f
C54 ua[4] ua[2] 5.50486f
C55 w_22268_1880# ua[2] 0.53599f **FLOATING
C56 ua[0] ua[2] 13.97601f
